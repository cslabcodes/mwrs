# Ansys Electronics Desktop project, version 2021.1
materials:
  vacuum: permittivity=1
  Rogers RT/duroid 5880 (tm): permittivity=2.2 dielectric_loss_tangent=0.0009

design HFSSDesign1 (HFSS, DrivenModal, model units mm)
options: Save_Adaptive_support_files
geometry:
  trace [vacuum] = imported_body()
  Substrate [Rogers RT/duroid 5880 (tm)] = imported_body()
  Port2, Port_diff, Port_sum, Port3 [vacuum] = imported_body()
boundaries and excitations:
  PerfE1: Perfect E Objects=trace
  Port2: Wave Port Objects=Port2 NumModes=1 Modes{Mode1{IntLine{middle of ?.edge(#1531) -> middle of ?.edge(#1515)} CharImp=Zpi}}
  Port3: Wave Port Objects=Port3 NumModes=1 Modes{Mode1{IntLine{middle of ?.edge(#1608) -> middle of ?.edge(#1517)} CharImp=Zpi}}
  Port_Sum: Wave Port Objects=Port_sum NumModes=1 Modes{Mode1{IntLine{middle of ?.edge(#1592) -> middle of ?.edge(#1516)} CharImp=Zpi}}
  Port_diff: Wave Port Objects=Port_diff NumModes=1 Modes{Mode1{IntLine{middle of ?.edge(#1575) -> middle of ?.edge(#1514)} CharImp=Zpi}}
mesh:
  initial mesh: GlobalCurvilinear{Apply}
setups:
  Setup1: HfssDriven Frequency=10GHz MaxDeltaS=0.01 MaximumPasses=12 MinimumPasses=1 MinimumConvergedPasses=1 PercentRefinement=30 BasisOrder=1 PortAccuracy=2 IESolverType=ACA
    sweep Sweep1: 8GHz to 12GHz step 0.1GHz; Type=Interpolating InterpTolerance=0.1 InterpMaxSolns=250 InterpUsePortImped=false
source amplitudes:
  Port2:1, Port3:1: 1 0deg
  Port_Sum:1, Port_diff:1: 0 0deg
output variables:
  Diff_port_phase = ang_deg(S(Port_diff,Port2))-ang_deg(S(Port_diff,Port3))
field plots:
  Mag_E1: E Field on Setup1 : LastAdaptive at Freq=10GHz Phase=0deg
reports:
  XY Plot 1: dB(S(Port_Sum,Port2)), dB(S(Port_Sum,Port3)) vs Freq on Setup1 : Sweep1
  XY Plot 2: Diff_port_phase vs Freq on Setup1 : Sweep1
