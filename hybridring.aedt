# Ansys Electronics Desktop project, version 2024.2
materials:
  vacuum: permittivity=1
  FR4_epoxy: permittivity=4.4 dielectric_loss_tangent=0.02
  air: permittivity=1.0006 permeability=1.0000004

design HFSSDesign1 (HFSS, HFSS Terminal Network, model units mm)
options: Allow_Material_Override
geometry:
  ring = circle(normal=Z, centre=(0mm, 0mm, 0mm), radius=17.52mm)
  innerCircle = circle(normal=Z, centre=(0mm, 0mm, 0mm), radius=15.9mm)
  ring.subtract(innerCircle)
  Rectangle1 = rectangle(corner=(-1.5mm, -40mm, 0mm), x_size=3mm, y_size=24mm)
  Rectangle1_1 = Rectangle1.duplicate_around_axis(axis=Z, angle=-90deg, total=2)
  Rectangle1_2 = Rectangle1.duplicate_around_axis(axis=Z, angle=90deg, total=2)
  Rectangle1_3 = Rectangle1.duplicate_around_axis(axis=Z, angle=30deg, total=2)
  Rectangle1.rotate(axis=Z, angle=-30deg)
  ring.unite(Rectangle1, Rectangle1_1, Rectangle1_2, Rectangle1_3)
  ring.rotate(axis=Z, angle=30deg)
  RegularPolyhedron1 [vacuum] = polyhedron(axis=Z, centre=(0mm, 0mm, 0mm), first_corner=(40/cos(30*pi/180) mm, 0mm, 0mm), sides=6, height=0mm)
  RegularPolyhedron2 [FR4_epoxy] = polyhedron(axis=Z, centre=(0mm, 0mm, 0mm), first_corner=(40/cos(30*pi/180) mm, 0mm, 0mm), sides=6, height=-1.6mm)
  RegularPolyhedron1.move(0mm, 7.1054274e-15mm, -1.6mm)
  [ring, RegularPolyhedron1, RegularPolyhedron2].rotate(axis=Z, angle=30deg)
  Rectangle2 = rectangle(corner=(40mm, -1.5mm, 0mm), y_size=3mm, z_size=-1.6mm)
  [ring, RegularPolyhedron1, RegularPolyhedron2, Rectangle2].rotate(axis=Z, angle=60deg)
  Rectangle3 = rectangle(corner=(40mm, -1.5mm, 0mm), y_size=3mm, z_size=-1.6mm)
  [ring, RegularPolyhedron1, RegularPolyhedron2, Rectangle2, Rectangle3].rotate(axis=Z, angle=60deg)
  Rectangle4 = rectangle(corner=(40mm, -1.5mm, 0mm), y_size=3mm, z_size=-1.6mm)
  [ring, RegularPolyhedron1, RegularPolyhedron2, Rectangle2, Rectangle3, Rectangle4].rotate(axis=Z, angle=-180deg)
  Rectangle5 = rectangle(corner=(40mm, -1.5mm, 0mm), y_size=3mm, z_size=-1.6mm)
  Radiation [air] = box(corner=(-50mm, -50mm, -50mm), size=(100mm, 100mm, 100mm))
boundaries and excitations:
  PerfE1: Perfect E Objects=ring
  PerfE2: Perfect E Objects=RegularPolyhedron1
  Rad1: Radiation Objects=Radiation
  1: Lumped Port Objects=Rectangle2 LumpedPortType=Modal Modes{Mode1{IntLine{(20, -34.641016, 0) -> (20, -34.641016, -1.6)} CharImp=Zpi}} Impedance=50ohm
  2: Lumped Port Objects=Rectangle4 LumpedPortType=Modal Modes{Mode1{IntLine{(-40, 0, 0) -> (-40, 0, -1.6)} CharImp=Zpi}} Impedance=50ohm
  3: Lumped Port Objects=Rectangle3 LumpedPortType=Modal Modes{Mode1{IntLine{(-20, -34.641016, 0) -> (-20, -34.641016, -1.6)} CharImp=Zpi}} Impedance=50ohm
  4: Lumped Port Objects=Rectangle5 LumpedPortType=Modal Modes{Mode1{IntLine{(40, 0, 0) -> (40, 0, -1.6)} CharImp=Zpi}} Impedance=50ohm
setups:
  Setup1: HfssDriven Frequency=2.4GHz MaxDeltaS=0.02 MaximumPasses=10 MinimumPasses=1 MinimumConvergedPasses=1 PercentRefinement=30 BasisOrder=1 PortAccuracy=2 DrivenSolverType="Direct Solver"
    sweep Sweep: 1GHz to 5GHz, 100 points; Type=Interpolating InterpTolerance=0.5 InterpMaxSolns=250 PassivityErrorTolerance=0.0001
source amplitudes:
  1:1: 1W 180deg
  2:1: 1W 0deg
  3:1, 4:1: 0W 0deg
field plots:
  Mag_E1: E Field over ring.face(at (0, -8.93551, 0)) RegularPolyhedron1.face(at (0, 0, -1.6)) on Setup1 : LastAdaptive at Freq=2.4GHz Phase=0deg
reports:
  S Parameter Plot 1: dB(S(1,1)), dB(S(1,2)), dB(S(1,3)), dB(S(1,4)) vs Freq on Setup1 : Sweep
